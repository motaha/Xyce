`include "frontdef.inc"

module bjtd504_va (c, b, e);

  // External ports
     inout c, b, e;

     electrical e, b, c;

  // Internal nodes
     electrical e1, b1, b2, c1, c2;

`include "parameters.inc"
`include "variables.inc"

analog begin

@(initial_model) begin
  `include "initialize.inc"
  `include "tscaling.inc"
end
`include "evaluate.inc"

end  // analog
endmodule
